* Делитель — ФИНАЛ: номиналы из нетлиста + диоды + транзисторы
.model QN NPN(IS=1E-14 BF=80 BR=1 VAF=100 RB=10 RC=1 RE=0.1)
.model D4148 D(IS=2.52n RS=0.568 N=1.752 CJO=2p M=0.4 TT=4n BV=100 IBV=1u)
VHV HVo 0 DC -1500
R401 HVo G 750k
R402 G DY1 750k
R403 DY1 DY2 680k
R404 DY2 DY3 680k
R405 DY3 DY4 680k
R406 DY4 DY5 680k
R407 DY5 Q401b 1.3Meg
R408 DY5 DY6 1.3Meg
R409 Q401b Q402b 1.6Meg
R410 Q402b Q403b 2Meg
R412 Q403b 0 2Meg
Vt1 DY7 c1 0
Q401 c1 Q401b DY6 QN
Vt2 DY8 c2 0
Q402 c2 Q402b DY7 QN
Vt3 0 c3 0
Q403 c3 Q403b DY8 QN
D401 DY6 Q401b D4148
D402 DY7 Q402b D4148
D403 DY8 Q403b D4148
.tran 1m uic
.meas TRAN Itot FIND I(R401) AT=1m
.meas TRAN Ic1 FIND I(Vt1) AT=1m
.meas TRAN Ic2 FIND I(Vt2) AT=1m
.meas TRAN Ic3 FIND I(Vt3) AT=1m
.meas TRAN Id1 FIND I(D401) AT=1m
.meas TRAN vG FIND V(G) AT=1m
.meas TRAN vDY1 FIND V(DY1) AT=1m
.meas TRAN vDY2 FIND V(DY2) AT=1m
.meas TRAN vDY3 FIND V(DY3) AT=1m
.meas TRAN vDY4 FIND V(DY4) AT=1m
.meas TRAN vDY5 FIND V(DY5) AT=1m
.meas TRAN vDY6 FIND V(DY6) AT=1m
.meas TRAN vDY7 FIND V(DY7) AT=1m
.meas TRAN vDY8 FIND V(DY8) AT=1m
.end
