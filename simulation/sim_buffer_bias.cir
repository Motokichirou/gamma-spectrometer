* =============================================================
* sim_buffer_bias.cir — DC рабочая точка буферов делителя (как в нетлисте)
* Проверка: есть ли квазиток смещения у Q401-Q403?
* Топология 1:1 из gamma_spectrometer.net (буферная секция).
* =============================================================
* Generic NPN ~ MMBTA42 (для DC-смещения важна топология, не модель)
.model QN NPN(IS=1E-14 BF=80 BR=1 VAF=100 RB=10 RC=1 RE=0.1)

* Верх секции: DY4 на расчётном потенциале (I_chain*ΣR от GND)
VDY4  DY4  0  DC -811

* Базирующая цепочка (наши номиналы), диноды НЕ на ней:
R406  DY4    DY5    680k
R407  DY5    NodeX  680k
R409  NodeX  NodeY  820k
R410  NodeY  NodeZ  1Meg
R412  NodeZ  0      1Meg

* Базовые резисторы (10к) от узлов цепочки к базам:
R408  Q401b  NodeX  10k
R411  Q402b  NodeY  10k
R413  Q403b  NodeZ  10k

* Транзисторы: Q <C> <B> <E>.  Эмиттеры = диноды DY6/7/8 (висят), коллекторы как в нетлисте.
* токовые сенсоры (0В) в коллекторах для замера Ic
Vc401 DY7 c401 0
Q401  c401  Q401b  DY6   QN
Vc402 DY8 c402 0
Q402  c402  Q402b  DY7   QN
Vc403 0   c403 0
Q403  c403  Q403b  DY8   QN

* диноды в темноте: вывод ФЭУ ≈ обрыв. Добавим реалистичную утечку 1ГОм на след. динод,
* чтобы не было висящего узла (это ДАЁТ путь тока — посмотрим, хватит ли его для смещения).
Rlk6 DY6 DY5 1000Meg
Rlk7 DY7 DY6 1000Meg
Rlk8 DY8 DY7 1000Meg

.tran 1m
.meas TRAN Ic_Q401 FIND I(Vc401) AT=1m
.meas TRAN Ic_Q402 FIND I(Vc402) AT=1m
.meas TRAN Ic_Q403 FIND I(Vc403) AT=1m
.meas TRAN V_DY6 FIND V(DY6) AT=1m
.meas TRAN V_DY7 FIND V(DY7) AT=1m
.meas TRAN V_DY8 FIND V(DY8) AT=1m
.end
