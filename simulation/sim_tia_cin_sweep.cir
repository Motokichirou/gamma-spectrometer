* =============================================================
* sim_tia_cin_sweep.cir — ЧЕСТНЫЙ свип по входной ёмкости (риск R-1)
* Пиковость меряется поточечно по |Zt(f)|, а НЕ через .meas MAX mag(),
* которая в sim_tia_stab.cir давала недостоверные числа.
* Схема — как в железе: Cf=4.7п фикс, выход через R418=33 Ом,
* коаксиал RG-178 100 мм и вход шейпера платы МК.
* =============================================================
.inc models/ada4817.cir

VCC VCC 0 DC 5
VEE VEE 0 DC -5

I_pmt 0 inn AC 1
.step param cin list 5p 10p 15p 20p 25p 30p 40p 50p
Cin   inn 0 {cin}

Rf  fb inn 499
Cf  fb inn 4.7p
X1  0 inn VCC VEE amp_out fb VCC ADA4817

R418 amp_out cbl 33
T1   cbl 0 rx 0 Z0=50 Td=0.48n
Cpar rx 0 3p
R309 rx cr_mid 10k
C315 cr_mid 0 100p
R314 cr_mid 0 10k

.ac dec 400 1k 1G

.meas AC zdc FIND mag(V(amp_out)) AT=10k
.meas AC f3db WHEN mag(V(amp_out))=zdc/1.41421 FALL=1
.meas AC z1 FIND mag(V(amp_out)) AT=1Meg
.meas AC z2 FIND mag(V(amp_out)) AT=2Meg
.meas AC z3 FIND mag(V(amp_out)) AT=3Meg
.meas AC z5 FIND mag(V(amp_out)) AT=5Meg
.meas AC z7 FIND mag(V(amp_out)) AT=7Meg
.meas AC z10 FIND mag(V(amp_out)) AT=10Meg
.meas AC z15 FIND mag(V(amp_out)) AT=15Meg
.meas AC z20 FIND mag(V(amp_out)) AT=20Meg
.meas AC z30 FIND mag(V(amp_out)) AT=30Meg
.meas AC z40 FIND mag(V(amp_out)) AT=40Meg
.meas AC z50 FIND mag(V(amp_out)) AT=50Meg
.meas AC z60 FIND mag(V(amp_out)) AT=60Meg
.meas AC z70 FIND mag(V(amp_out)) AT=70Meg
.meas AC z80 FIND mag(V(amp_out)) AT=80Meg
.meas AC z90 FIND mag(V(amp_out)) AT=90Meg
.meas AC z100 FIND mag(V(amp_out)) AT=100Meg
.meas AC z120 FIND mag(V(amp_out)) AT=120Meg
.meas AC z140 FIND mag(V(amp_out)) AT=140Meg
.meas AC z160 FIND mag(V(amp_out)) AT=160Meg
.meas AC z180 FIND mag(V(amp_out)) AT=180Meg
.meas AC z200 FIND mag(V(amp_out)) AT=200Meg
.meas AC z250 FIND mag(V(amp_out)) AT=250Meg
.meas AC z300 FIND mag(V(amp_out)) AT=300Meg
.meas AC z350 FIND mag(V(amp_out)) AT=350Meg
.meas AC z400 FIND mag(V(amp_out)) AT=400Meg
.meas AC z450 FIND mag(V(amp_out)) AT=450Meg
.meas AC z500 FIND mag(V(amp_out)) AT=500Meg
.meas AC z600 FIND mag(V(amp_out)) AT=600Meg

.end
