* =============================================================
* sim_tia_lfb.cir — TIA ADA4817 с паразитами разводки делителя (FastCap/FastHenry, 2026-09-19)
*   Lfb  — индуктивность петли обратной связи вывод1 → R417‖C415 → вывод2 (FastHenry: 10.7 нГн)
*   Lsp/Lsn — петли развязки питания (FastHenry LP5: 4.6 нГн; для −5 В берётся столько же)
*   Cin  — ёмкость суммирующего узла (FastCap: ~4 пФ с выводами ФЭУ; 10 пФ — с запасом)
* Выход без последовательного R (как в схеме), кабель RG-178 100 мм, вход шейпера платы МК.
* Анализ — поточечно по .raw (tia_lfb_analyze в README), не через .meas MAX.
* =============================================================
.inc ../models/ada4817.cir
.step param lfb list 1p 10.7n
.step param cin list 4p 10p

* питание: источник -> 1 мкГн (дальний путь) -> развязка 0.1 мкФ + ESR -> Ls петли -> вывод ОУ
VCC  vcc0 0 DC 5
VEE  vee0 0 DC -5
Lbp  vcc0 cp 1u
Lbn  vee0 cn 1u
C414 cp cpe 0.1u
Rcp  cpe 0 10m
C412 cn cne 0.1u
Rcn  cne 0 10m
Lsp  cp VCCp 4.6n
Lsn  cn VEEp 4.6n

I_pmt 0 inn AC 1
Cin   inn 0 {cin}

Lfb  fb fbn {lfb}
Rf   fbn inn 499
Cf   fbn inn 4.7p
X1   0 inn VCCp VEEp amp_out fb VCCp ADA4817

T1   amp_out 0 rx 0 Z0=50 Td=0.48n
Cpar rx 0 3p
R309 rx cr_mid 10k
C315 cr_mid 0 100p
R314 cr_mid 0 10k

.save V(amp_out)
.ac dec 400 1k 3G
.end
