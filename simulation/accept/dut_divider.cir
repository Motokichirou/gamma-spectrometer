* =============================================================
* dut_divider.cir — DUT делителя ФЭУ R1307 (правится ТОЛЬКО этот файл)
* Цепочка R401-R414 + 3 NPN-буфера Q401-403 (Dy6/7/8) + базовые R408/411/413.
* Значения сверены с pcb/gamma_spectrometer.net (R401/402=750k, R403-407=680k,
* R409=820k, R410=1M, R412/414=499k, базовые 10k). Включается флэтом из c1_bench.cir.
* Узлы: cath(катод), gnode(фокус G), dy1..dy5, cd6/cd7/cd8 (узлы цепочки Dy6-8),
*        DY6/DY7/DY8 (буферир. диноды = эмиттеры), midP (R412/R414, =коллектор Q403), 0(анод).
* C1-ФИКС меняет ПИТАНИЕ КОЛЛЕКТОРОВ Q401-403 (сейчас от мягких узлов DY7/DY8/midP).
* =============================================================

* --- резистивная цепочка (анод 0 -> катод) ---
R412 cd8   0     1Meg     ; ФИКС C1 (как в железе): R414 убран, R412=1M cd8->GND, midP исключён
R410 cd8   cd7   1Meg
R409 cd7   cd6   820k
R407 cd6   dy5   680k
R406 dy5   dy4   680k
R405 dy4   dy3   680k
R404 dy3   dy2   680k
R403 dy2   dy1   680k
R402 dy1   gnode 750k
R401 gnode cath  750k

* --- базовые резисторы буферов (узел цепочки -> база) ---
R413 cd8 b8 10k
R411 cd7 b7 10k
R408 cd6 b6 10k

* --- буферы (эмиттерные повторители): Q <коллектор> <база> <эмиттер> ---
* СЕЙЧАС коллекторы от мягких узлов делителя (механизм C1):
Q403 0    b8 DY8 QN     ; ФИКС C1: коллектор на жёсткую землю (анод), не midP
Q402 DY8  b7 DY7 QN     ; C=DY8
Q401 DY7  b6 DY6 QN     ; C=DY7

.model QN NPN(BF=80 IS=1e-15 VAF=120 RB=10 RC=5)
