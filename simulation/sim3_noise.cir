* =============================================================
* sim3_noise.cir  —  CR-RC² шейпер: анализ шума
* Gamma spectrometer ADC/MCU board v1.5
* =============================================================
*
* Цель: σ_total на V(adc_in) < 150 мкВ rms (обновлённый бюджет PGA x4)
*
* Метод: LTspice .noise analysis
*   - DC operating point: от делителей VREF
*   - Источники шума: тепловой шум R, шум G474 (R_vn=151Ω → 50 нВ/√Гц)
*                     шум AD8000 (R_ad8_noise=166Ω → 1.66 нВ/√Гц доп. к Rin||Rg)
*   - Результат: Total output noise voltage в логе = σ_total
*
* Libraries
.lib models/opamp_g474_noise.sub

* =============================================================
* SUPPLIES
* =============================================================
VDD   VDD   0   DC  3.3
VREF  VREF  0   DC  2.5

* =============================================================
* INPUT: AC current source (1 A) для расчёта S/N.
* DC=0 → цепь стоит в рабочей точке от делителей смещения.
* =============================================================
I_pmt  0  anode  AC 1  DC 0

Rin    anode   0        50
Rg     anode   0        100

* =============================================================
* AD8000 шум: дополнительный к тепловому Rin||Rg
* e_n_device = sqrt(1.6^2 + 0.28^2 + 0.33^2) = 1.66 нВ/√Гц
* R_eq = (1.66e-9)^2 / (4kT) = 166 Ом  (at T=300K)
* =============================================================
R_ad8_noise  anode  anode_int  166

* AD8000: идеальный VCVS, усиление x15
E_ad8   amp_out   0   0   anode_int   15

* =============================================================
* DC BIAS DIVIDERS from REF3025 (2.5V)
* =============================================================
Ra   VREF  vbias_a  8.2k
Rb   vbias_a  0     2k
Ca   vbias_a  0     100n

Rc   VREF  vbias_b  22k
Rd   vbias_b  0     5.9k
Cb   vbias_b  0     100n

* =============================================================
* OPAMP1: CR high-pass (inverting), H_CR = -s*tau/(1+s*tau)
* =============================================================
R_cr_in  amp_out  cr_mid  10k
C_diff   cr_mid   cr_in   100p
R_diff   cr_out   cr_in   10k

XU1  vbias_a  cr_in  VDD  0  cr_out  opamp_g474_noise

* =============================================================
* AC coupling OPAMP1 -> OPAMP2
* =============================================================
C_couple  cr_out   rc_node  100n

* =============================================================
* OPAMP2: RC integrator (inverting), H_RC = -1/(1+s*tau_int)
* =============================================================
R_int    rc_node   rc_in   1k
C_int    rc_out    rc_in   510p
R_stab   rc_out    rc_in   1k

XU2  vbias_a  rc_in  VDD  0  rc_out  opamp_g474_noise

* =============================================================
* AC coupling OPAMP2 -> OPAMP3
* =============================================================
C_buf_in  rc_out  pga_inp  100n
Rbias_pga  vbias_b  pga_inp  4.65k

* =============================================================
* OPAMP3: PGA x4 (non-inverting)
* =============================================================
R_pga1   adc_in   pga_inm  30k
R_pga2   pga_inm  0        10k

XU3  pga_inp  pga_inm  VDD  0  adc_in  opamp_g474_noise

* =============================================================
* NOISE + AC ANALYSIS
* Диапазон: 1 Гц ... 2 МГц (Nyquist при 4 Мвыб/с)
* =============================================================
.noise V(adc_in) I_pmt dec 100 1 2Meg

.backanno
.end
