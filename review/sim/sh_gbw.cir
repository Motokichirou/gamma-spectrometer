* sh_gbw.cir — REVIEW: влияние GBW встроенного ОУ G474 на форму/амплитуду CR-RC2
* Сравнение: реальный G474 (GBW=13МГц) vs почти идеальный ОУ (GBW=2ГГц).
* Если PF сильно зависит от GBW — значит форму определяет полоса ОУ, а не RC-номиналы.
* Цепочка идентична sim2_shaper.cir, но ОУ — параметрический одно-полюсный.
.param Aol=100k
.param GBW=13Meg
.step param GBW list 13Meg 2Gig

VDD VDD 0 DC 3.3
VREF VREF 0 DC 2.5

.param tau_d=230n
.param I_peak=0.94m
I_pmt 0 anode EXP(0 {I_peak} 500n 5n 505n {tau_d})
Rin anode 0 50
Rg  anode 0 100
E_ad8 amp_out 0 0 anode 15

Ra VREF vbias_a 8.2k
Rb vbias_a 0 2k
Ca vbias_a 0 100n
Rc VREF vbias_b 22k
Rd vbias_b 0 5.9k
Cb vbias_b 0 100n

R_cr_in amp_out cr_mid 10k
C_diff  cr_mid cr_in 100p
R_diff  cr_out cr_in 10k
XU1 vbias_a cr_in cr_out oa

C_couple cr_out rc_node 100n
R_int rc_node rc_in 1k
C_int rc_out rc_in 510p
R_stab rc_out rc_in 1k
XU2 vbias_a rc_in rc_out oa

C_buf_in rc_out pga_inp 100n
Rbias_pga vbias_b pga_inp 4.65k
R_pga1 adc_in pga_inm 30k
R_pga2 pga_inm 0 10k
XU3 pga_inp pga_inm adc_in oa

.subckt oa INP INM OUT
G1 0 OUT INP INM {Aol}
R3 OUT 0 1
C3 OUT 0 {Aol/GBW/6.28318530718}
.ends

.save V(amp_out) V(adc_in)
.tran 1n 8u
.meas TRAN bl_adc  AVG V(adc_in)  FROM 200n TO 400n
.meas TRAN adc_min MIN V(adc_in)  FROM 500n TO 4u
.meas TRAN bl_amp  AVG V(amp_out) FROM 200n TO 400n
.meas TRAN amp_min MIN V(amp_out) FROM 500n TO 4u
.end
